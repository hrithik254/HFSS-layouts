# Ansys Electronics Desktop project, version 2025.1
materials:
  air: permittivity=1.0006 permeability=1.0000004
  gallium_arsenide: permittivity=12.9 conductivity=1e-05 dielectric_loss_tangent=0.0001
  gold: permeability=0.99996 conductivity=41000000
  sapphire: permittivity=9.4 dielectric_loss_tangent=2e-05
  vacuum: permittivity=1

design CPW_transition (HFSS, HFSS Terminal Network, model units mm)
variables:
  subx = 6.5mm
  suby = s + 2*(g+gnd_width) + 600um
  subz = 500um
  s = 40um
  g = 25.5um
  gnd_width = 180um
  Tmet = 2um
  air_box_h = subz + 15000um
  porty = 3*(2*g+s)
  portz = 2*subz
  airx = subx
  airy = suby+15000um
  abpillarx = 20um
  abpillary = 20um
  abpillarz = 4um
  transition_gap = 4000um
  pillarh = 2.6um
  sig_p_r = 12.5um
  overlay_pad = overlay_tol
  g_pillar_seperation = 100um
  gnd_p_r = 12.5um
  chipx = transition_gap+ 2*overlay_tol + 2*dielectric_overlap
  chipy = suby
  overlay_tol = 10um
  dielectric_overlap = 0.5mm
  chip_s = 40um
  chip_g = 25.5um
  chip_gnd_width = 180um
  bonder_tol = 20um
  trace_overlap = transition_gap + 2* overlay_tol + 4*gnd_p_r + bonder_tol
geometry:
  substrate [sapphire] = box(corner=(-subx/2, -suby/2, 0mm), size=(subx, suby, subz))
  signal_dummy [vacuum, non-model] = substrate.section(plane=ZX)
  signal_dummy.thicken(s, both sides)
  gap_dummy1 [vacuum, non-model] = sweep_along_normal(signal_dummy.face(at (0, -0.03, 0.25)), length=g)
  gap_dummy2 [vacuum, non-model] = sweep_along_normal(signal_dummy.face(at (0, 0.03, 0.25)), length=g)
  gnd_dummy1 [vacuum, non-model] = sweep_along_normal(gap_dummy1.face(at (0, -0.0585, 0.25)), length=gnd_width)
  gnd_dummy2 [vacuum, non-model] = sweep_along_normal(gap_dummy2.face(at (0, 0.0585, 0.25)), length=gnd_width)
  port1 = rectangle(corner=(subx/2, -porty/2, 50um), y_size=porty, z_size=portz)
  port2 = rectangle(corner=(-subx/2, -porty/2, 50um), y_size=porty, z_size=portz)
  airbox [air] = box(corner=(-airx/2, -airy/2, -air_box_h/2), size=(airx, airy, air_box_h))
  backside_gnd [gold] = sweep_along_normal(substrate.face(-z), length=2um)
  substrate_Section1 = substrate.section(plane=YZ)
  substrate_Section1.thicken(transition_gap, both sides)
  substrate_Section1_1 = substrate_Section1.copy()
  gap_dummy1.subtract(substrate_Section1_1)
  substrate_Section1_2 = substrate_Section1.copy()
  gap_dummy2.subtract(substrate_Section1_2)
  substrate_Section1_3 = substrate_Section1.copy()
  gnd_dummy1.subtract(substrate_Section1_3)
  substrate_Section1_4 = substrate_Section1.copy()
  gnd_dummy2.subtract(substrate_Section1_4)
  signal_dummy.subtract(substrate_Section1)
  gnd1_1, gnd1_2 [gold] = sweep_along_normal(gnd_dummy1.face(at (2.625, -0.1355, 0.5), at (-2.625, -0.1355, 0.5)), length=Tmet)
  signal1, signal2 [gold] = sweep_along_normal(signal_dummy.face(at (2.625, 0, 0.5), at (-2.625, 0, 0.5)), length=Tmet)
  gnd2_1, gnd2_2 [gold] = sweep_along_normal(gnd_dummy2.face(at (2.625, 0.1355, 0.5), at (-2.625, 0.1355, 0.5)), length=Tmet)
  p_sig_1 [gold] = cylinder(axis=Z, base_centre=(transition_gap/2 + sig_p_r  + overlay_pad, 0mm, subz+Tmet), radius=sig_p_r, height=pillarh)
  p_sig_2 [gold] = p_sig_1.duplicate_mirror(point=(0mm, 0mm, 0mm), normal=(-1mm, 0mm, 0mm))
  p_gnd_1_1 [gold] = cylinder(axis=Z, base_centre=(transition_gap/2 + sig_p_r  + overlay_pad, -g -s/2 - g_pillar_seperation, subz+Tmet), radius=gnd_p_r, height=pillarh)
  p_gnd_2_1 [gold] = p_gnd_1_1.duplicate_mirror(point=(0.53mm, 0mm, 0.502mm), normal=(2.7755576e-14mm, 1mm, 0mm))
  p_gnd_1_2 [gold] = p_gnd_1_1.duplicate_mirror(point=(0mm, 0mm, 0mm), normal=(-1mm, 0mm, 0mm))
  p_gnd_2_2 [gold] = p_gnd_2_1.duplicate_mirror(point=(0mm, 0mm, 0mm), normal=(-1mm, 0mm, 0mm))
  chip [sapphire] = box(corner=(-chipx/2, -chipy/2, subz+2*Tmet+pillarh), size=(chipx, chipy, subz))
  chip_signal_dummy [gallium_arsenide, non-model] = chip.section(plane=ZX)
  chip_signal_dummy.thicken(chip_s, both sides)
  chip_gap_dummy2, chip_gap_dummy1 [gallium_arsenide, non-model] = sweep_along_normal(chip_signal_dummy.face(at (0, 0.02, 0.7566), at (0, -0.02, 0.7566)), length=chip_g)
  chip_gnd_dummy2 [gallium_arsenide, non-model] = sweep_along_normal(chip_gap_dummy2.face(at (0, 0.0455, 0.7566)), length=chip_gnd_width)
  chip_gnd_dummy1 [gallium_arsenide, non-model] = sweep_along_normal(chip_gap_dummy1.face(at (0, -0.0455, 0.7566)), length=chip_gnd_width)
  chip_Section1_Section1 [gallium_arsenide, non-model] = chip_signal_dummy.section(plane=YZ)
  chip_Section1_SweepFaceAlongNormal1_Section1 [gallium_arsenide, non-model] = chip_gap_dummy2.section(plane=YZ)
  chip_Section1_SweepFaceAlongNormal2_Section1 [gallium_arsenide, non-model] = chip_gap_dummy1.section(plane=YZ)
  chip_Section1_SweepFaceAlongNormal1_SweepFaceAlongNormal1_Section1 [gallium_arsenide, non-model] = chip_gnd_dummy2.section(plane=YZ)
  chip_Section1_SweepFaceAlongNormal2_SweepFaceAlongNormal1_Section1 [gallium_arsenide, non-model] = chip_gnd_dummy1.section(plane=YZ)
  [chip_Section1_Section1, chip_Section1_SweepFaceAlongNormal1_Section1, chip_Section1_SweepFaceAlongNormal2_Section1, chip_Section1_SweepFaceAlongNormal1_SweepFaceAlongNormal1_Section1, chip_Section1_SweepFaceAlongNormal2_SweepFaceAlongNormal1_Section1].thicken(trace_overlap, both sides)
  chip_gnd1 [gold] = sweep_along_normal(chip_Section1_SweepFaceAlongNormal2_SweepFaceAlongNormal1_Section1.face(at (0, -0.1355, 0.5066)), length=Tmet)
  chip_gnd2 [gold] = sweep_along_normal(chip_Section1_SweepFaceAlongNormal1_SweepFaceAlongNormal1_Section1.face(at (0, 0.1355, 0.5066)), length=Tmet)
  chip_signal [gold] = sweep_along_normal(chip_Section1_Section1.face(at (0, 0, 0.5066)), length=Tmet)
boundaries and excitations:
  Rad1: Radiation Faces=airbox.face(-y, +z, -z, +y)
  Rad2: Radiation Faces=airbox.face(+x, -x)
  PerfE1: Perfect E Faces=backside_gnd.face(at (0, 0, -0.002))
  1: Wave Port Objects=port1 WavePortType=Modal NumModes=1 Modes{Mode1{IntLine{(3.25, 0.02, 0.502) -> (3.25, 0.0455, 0.502)} CharImp=Zpv RenormImp=50ohm}}
  2: Wave Port Objects=port2 WavePortType=Modal NumModes=1 Modes{Mode1{IntLine{(-3.25, 0.02, 0.502) -> (-3.25, 0.0455, 0.502)} CharImp=Zpv RenormImp=50ohm}}
setups:
  broadband: HfssDriven MultipleAdaptiveFreqsSetup{Low=27GHz High=45GHz} MaxDeltaS=0.02 MaximumPasses=15 MinimumPasses=1 MinimumConvergedPasses=1 PercentRefinement=30 BasisOrder=1 PortAccuracy=0.1 UseABCOnPort DrivenSolverType="Direct Solver" SaveAnyFields=false
    sweep Sweep: 1GHz to 45GHz, 201 points; Type=Interpolating InterpTolerance=0.5 InterpMaxSolns=250 PassivityErrorTolerance=0.0001
source amplitudes:
  1:1: 1V 0deg
  2:1: 0V 0deg
output variables:
  Zo = 50*(1 + re(St(signal_conductor_T1,signal_conductor_T1)))/(1-re(St(signal_conductor_T1,signal_conductor_T1)))
  lost_power_fraction = 1-(mag(St(1,1))^2 + mag(St(2,1))^2)
reports:
  Terminal S Parameter Plot1: dB(St(1,1)) vs Freq on broadband : Sweep; markers m1 at 27GHz, m2 at 40GHz
  Terminal S Parameter Plot2: dB(St(1,2)) vs Freq on broadband : Sweep; markers m1 at 27GHz, m2 at 40GHz
  Terminal S Parameter Chart1: St(1,1) on broadband : Sweep [Freq=all]
  Terminal S Parameter Chart2: St(1,2) on broadband : Sweep [Freq=all]
  Terminal Port Zo Plot1: re(Zot(1,1)) vs Freq on broadband : Sweep; markers MX1 at x=3.35e+10, MX2 at x=2.7e+10, MX3 at x=4e+10
  Output Variables Plot2: lost_power_fraction vs Freq on broadband : Sweep; markers m1 at 27GHz, m2 at 40GHz
