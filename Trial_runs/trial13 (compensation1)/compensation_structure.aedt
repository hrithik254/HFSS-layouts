# Ansys Electronics Desktop project, version 2025.1
materials:
  vacuum: permittivity=1
  gold: permeability=0.99996 conductivity=41000000
  sapphire: permittivity=9.4 dielectric_loss_tangent=2e-05

design HFSSDesign1 (HFSS, HFSS Terminal Network, model units mm)
variables:
  subx = 2mm
  suby = 1.5mm
  subz = 0.5mm
  signal = 24.5um
  gap = 10.12um
  gnd_width = 3*signal
  Tmet = 2um
  gpillar_r = 10um
  pillar_h = 50um
  mask_align_tol = 40um
  spillar_r = gpillar_r
  porty = 3*(2*gap+signal)
  portz = subz
  trace_overlap = mask_align_tol+2*gpillar_r+bonder_tol
  bonder_tol = 50um
geometry:
  substrate [sapphire] = box(corner=(-subx/2, -suby/2, 0mm), size=(subx, suby, subz))
  substrate_signal_dummy = substrate.section(plane=ZX)
  bottom_gnd [gold] = sweep_along_normal(substrate.face(-z), length=Tmet)
  substrate_signal_dummy.thicken(signal, both sides)
  substrate_gap1_dummy = sweep_along_normal(substrate_signal_dummy.face(#448), length=gap)
  substrate_gap2_dummy = sweep_along_normal(substrate_signal_dummy.face(at (0, 0.01225, 0.25)), length=gap)
  substrate_gnd2_dummy = sweep_along_normal(substrate_gap2_dummy.face(at (0, 0.02237, 0.25)), length=gnd_width)
  substrate_gnd2_dummy.split(plane=YZ, keep=PositiveOnly)
  gnd_2 [gold] = sweep_along_normal(substrate_gnd2_dummy.face(at (0.5, 0.05912, 0.5)), length=Tmet)
  [substrate_gap2_dummy, substrate_gnd2_dummy].delete()
  substrate_signal_dummy.split(plane=YZ, keep=PositiveOnly)
  signal [gold] = sweep_along_normal(substrate_signal_dummy.face(at (0.5, 0, 0.5)), length=Tmet)
  substrate_signal_dummy.delete()
  substrate_gnd1_dummy = sweep_along_normal(substrate_gap1_dummy.face(at (0, -0.02237, 0.25)), length=gnd_width)
  substrate_gnd1_dummy.split(plane=YZ, keep=PositiveOnly)
  gnd_1 [gold] = sweep_along_normal(substrate_gnd1_dummy.face(at (0.5, -0.05912, 0.5)), length=Tmet)
  [substrate_gap1_dummy, substrate_gnd1_dummy].delete()
  Cylinder1 [gold] = cylinder(axis=Z, base_centre=(mask_align_tol+gpillar_r, -signal/2-gap-gnd_width/2, subz+Tmet), radius=gpillar_r, height=pillar_h)
  Cylinder1_1 [gold] = Cylinder1.duplicate_mirror(point=(0mm, 0mm, 0mm), normal=(0mm, 2*gap+signal+gnd_width +2*gpillar_r, 0mm))
  Cylinder2 [gold] = cylinder(axis=Z, base_centre=(mask_align_tol +spillar_r, 0, subz+Tmet), radius=0.01mm, height=pillar_h)
  chip [sapphire] = box(corner=(-subx/2, -suby/2, subz+2*Tmet+pillar_h), size=(subx, suby, subz))
  chip.split(plane=YZ, keep=NegativeOnly)
  trace_overlap [sapphire] = sweep_along_normal(chip.face(at (0, 0, 0.804)), length=trace_overlap)
  chip_signal_dummy = chip.section(plane=ZX)
  Port2 = rectangle(corner=(-subx/2, -porty/2, -portz/2+subz+pillar_h+Tmet), y_size=porty, z_size=portz)
  Port1 = Port2.duplicate_mirror(point=(0mm, 0mm, pillar_h), normal=(subx, 0mm, 0mm))
  trace_overlap_signal_dummy = trace_overlap.section(plane=ZX)
  chip_signal_dummy.thicken(signal, both sides)
  chip_gap1_dummy = sweep_along_normal(chip_signal_dummy.face(at (-0.5, -0.01225, 0.804)), length=gap)
  chip_gap2_dummy = sweep_along_normal(chip_signal_dummy.face(at (-0.5, 0.01225, 0.804)), length=gap)
  chip_Section1_SweepFaceAlongNormal3 [gold] = sweep_along_normal(chip_signal_dummy.face(at (-0.5, 0, 0.554)), length=Tmet)
  chip_signal_dummy.delete()
  trace_overlap_signal_dummy.thicken(signal, both sides)
  trace_overlap_gap1_dummy = sweep_along_normal(trace_overlap_signal_dummy.face(at (0.055, -0.01225, 0.804)), length=gap)
  trace_overlap_gap2_dummy = sweep_along_normal(trace_overlap_signal_dummy.face(at (0.055, 0.01225, 0.804)), length=gap)
  chip_SweepFaceAlongNormal1_Section1_SweepFaceAlongNormal3 [gold] = sweep_along_normal(trace_overlap_signal_dummy.face(at (0.055, 0, 0.554)), length=Tmet)
  trace_overlap_signal_dummy.delete()
  chip_gnd1_dummy = sweep_along_normal(chip_gap1_dummy.face(at (-0.5, -0.02237, 0.804)), length=gnd_width)
  chip_Section1_SweepFaceAlongNormal1_SweepFaceAlongNormal1_SweepFaceAlongNormal1 [gold] = sweep_along_normal(chip_gnd1_dummy.face(at (-0.5, -0.05912, 0.554)), length=Tmet)
  [chip_gap1_dummy, chip_gnd1_dummy].delete()
  trace_overlap_gnd1_dummy = sweep_along_normal(trace_overlap_gap1_dummy.face(at (0.055, -0.02237, 0.804)), length=gnd_width)
  chip_SweepFaceAlongNormal1_Section1_SweepFaceAlongNormal1_SweepFaceAlongNormal1_SweepFaceAlongNormal1 [gold] = sweep_along_normal(trace_overlap_gnd1_dummy.face(at (0.055, -0.05912, 0.554)), length=Tmet)
  [trace_overlap_gap1_dummy, trace_overlap_gnd1_dummy].delete()
  chip_gnd2_dummy = sweep_along_normal(chip_gap2_dummy.face(at (-0.5, 0.02237, 0.804)), length=gnd_width)
  chip_Section1_SweepFaceAlongNormal2_SweepFaceAlongNormal1_SweepFaceAlongNormal1 [gold] = sweep_along_normal(chip_gnd2_dummy.face(at (-0.5, 0.05912, 0.554)), length=Tmet)
  [chip_gap2_dummy, chip_gnd2_dummy].delete()
  trace_overlap_gnd2_dummy = sweep_along_normal(trace_overlap_gap2_dummy.face(at (0.055, 0.02237, 0.804)), length=gnd_width)
  chip_SweepFaceAlongNormal1_Section1_SweepFaceAlongNormal2_SweepFaceAlongNormal1_SweepFaceAlongNormal1 [gold] = sweep_along_normal(trace_overlap_gnd2_dummy.face(at (0.055, 0.05912, 0.554)), length=Tmet)
  [trace_overlap_gap2_dummy, trace_overlap_gnd2_dummy].delete()
boundaries and excitations:
  1: Wave Port Objects=Port1 WavePortType=Modal NumModes=1 Modes{Mode1{IntLine{(1, 0.01225, 0.502) -> (1, 0.02237, 0.502)} CharImp=Zpv RenormImp=50ohm}}
  2: Wave Port Objects=Port2 WavePortType=Modal NumModes=1 Modes{Mode1{IntLine{(-1, 0.01225, 0.554) -> (-1, 0.02237, 0.554)} CharImp=Zpv RenormImp=50ohm}}
source amplitudes:
  1:1: 1V 0deg
  2:1: 0V 0deg
