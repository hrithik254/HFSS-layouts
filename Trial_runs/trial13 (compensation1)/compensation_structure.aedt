# Ansys Electronics Desktop project, version 2025.1
materials:
  vacuum: permittivity=1
  gold: permeability=0.99996 conductivity=41000000
  sapphire: permittivity=9.4 dielectric_loss_tangent=2e-05
  air: permittivity=1.0006 permeability=1.0000004

design narrowline_comp (HFSS, HFSS Terminal Network, model units mm)
variables:
  subx = 1mm
  suby = 1.5mm
  subz = 0.5mm
  signal = 24.5um
  gap = 10.12um
  gnd_width = 180um
  Tmet = 2um
  gpillar_r = 10um
  pillar_h = 50um
  mask_align_tol = 40um
  spillar_r = gpillar_r
  porty = 3*(2*gap+signal)
  portz = 2*subz
  trace_overlap = mask_align_tol+2*gpillar_r+bonder_tol
  bonder_tol = 50um
  airx = subx
  airz = 2*subz + 15000um
  airy = suby + 15000um
  comp_len = 100um  # optimise 13.5um..40.5um
  comp_width = 5um  # optimise 5.25um..15.75um
  port_elevation = 0um
  dielectric_overlap = 0.2mm
geometry:
  substrate [sapphire] = box(corner=(-subx/2, -suby/2, 0mm), size=(subx, suby, subz))
  substrate_signal_dummy [sapphire, non-model] = substrate.section(plane=ZX)
  substrate_signal_dummy.thicken(signal, both sides)
  substrate_gap1_dummy [sapphire, non-model] = sweep_along_normal(substrate_signal_dummy.face(at (0, -0.01225, 0.25)), length=gap)
  substrate_gap2_dummy [sapphire, non-model] = sweep_along_normal(substrate_signal_dummy.face(at (0, 0.01225, 0.25)), length=gap)
  substrate_signal_dummy.split(plane=YZ, keep=PositiveOnly)
  substrate_gnd1_dummy [sapphire, non-model] = sweep_along_normal(substrate_gap1_dummy.face(at (0, -0.02237, 0.25)), length=gnd_width)
  [substrate_gap1_dummy, substrate_gnd1_dummy].split(plane=YZ, keep=PositiveOnly)
  substrate_gnd_1 [gold] = sweep_along_normal(substrate_gnd1_dummy.face(at (0.25, -0.11237, 0.5)), length=Tmet)
  substrate_gnd2_dummy [sapphire, non-model] = sweep_along_normal(substrate_gap2_dummy.face(at (0, 0.02237, 0.25)), length=gnd_width)
  [substrate_gap2_dummy, substrate_gnd2_dummy].split(plane=YZ, keep=PositiveOnly)
  substrate_gnd_2 [gold] = sweep_along_normal(substrate_gnd2_dummy.face(at (0.25, 0.11237, 0.5)), length=Tmet)
  gnd1_pillar [gold] = cylinder(axis=Z, base_centre=(mask_align_tol+gpillar_r, -signal/2-gap-gnd_width/2, subz+Tmet), radius=gpillar_r, height=pillar_h)
  gnd2_pillar [gold] = gnd1_pillar.duplicate_mirror(point=(0mm, 0mm, 0mm), normal=(0mm, 2*gap+signal+gnd_width +2*gpillar_r, 0mm))
  sig_pillar [gold] = cylinder(axis=Z, base_centre=(mask_align_tol +spillar_r, 0, subz+Tmet), radius=0.01mm, height=pillar_h)
  chip [sapphire] = box(corner=(-subx/2, -suby/2, subz+2*Tmet+pillar_h), size=(subx, suby, subz))
  chip.split(plane=YZ, keep=NegativeOnly)
  trace_overlap [sapphire] = sweep_along_normal(chip.face(at (0, 0, 0.804)), length=trace_overlap)
  chip_signal_dummy [sapphire, non-model] = chip.section(plane=ZX)
  Port2 = rectangle(corner=(-subx/2, -porty/2, -portz/2+subz+Tmet+pillar_h+port_elevation), y_size=porty, z_size=portz)
  Port1 = Port2.duplicate_mirror(point=(0mm, 0mm, pillar_h), normal=(subx, 0mm, 0mm))
  trace_overlap_signal_dummy [sapphire, non-model] = trace_overlap.section(plane=ZX)
  trace_overlap_signal_dummy.thicken(signal, both sides)
  trace_overlap_gap1_dummy [sapphire, non-model] = sweep_along_normal(trace_overlap_signal_dummy.face(at (0.055, -0.01225, 0.804)), length=gap)
  trace_overlap_gap2_dummy [sapphire, non-model] = sweep_along_normal(trace_overlap_signal_dummy.face(at (0.055, 0.01225, 0.804)), length=gap)
  chip_signal_overlap [gold] = sweep_along_normal(trace_overlap_signal_dummy.face(at (0.055, 0, 0.554)), length=Tmet)
  chip_signal_dummy.thicken(signal, both sides)
  chip_gap1_dummy [sapphire, non-model] = sweep_along_normal(chip_signal_dummy.face(at (-0.25, -0.01225, 0.804)), length=gap)
  chip_gap2_dummy [sapphire, non-model] = sweep_along_normal(chip_signal_dummy.face(at (-0.25, 0.01225, 0.804)), length=gap)
  chip_signal [gold] = sweep_along_normal(chip_signal_dummy.face(at (-0.25, 0, 0.554)), length=Tmet)
  chip_gnd1_dummy [sapphire, non-model] = sweep_along_normal(chip_gap1_dummy.face(at (-0.25, -0.02237, 0.804)), length=gnd_width)
  trace_overlap_gnd1_dummy [sapphire, non-model] = sweep_along_normal(trace_overlap_gap1_dummy.face(at (0.055, -0.02237, 0.804)), length=gnd_width)
  chip_gnd2_dummy [sapphire, non-model] = sweep_along_normal(chip_gap2_dummy.face(at (-0.25, 0.02237, 0.804)), length=gnd_width)
  trace_overlap_gnd2_dummy [sapphire, non-model] = sweep_along_normal(trace_overlap_gap2_dummy.face(at (0.055, 0.02237, 0.804)), length=gnd_width)
  chip_gnd_1_overlap [gold] = sweep_along_normal(trace_overlap_gnd1_dummy.face(at (0.055, -0.11237, 0.554)), length=Tmet)
  chip_gnd_1 [gold] = sweep_along_normal(chip_gnd1_dummy.face(at (-0.25, -0.11237, 0.554)), length=Tmet)
  chip_gnd_2 [gold] = sweep_along_normal(chip_gnd2_dummy.face(at (-0.25, 0.11237, 0.554)), length=Tmet)
  chip_gnd_2_overlap [gold] = sweep_along_normal(trace_overlap_gnd2_dummy.face(at (0.055, 0.11237, 0.554)), length=Tmet)
  air_box [air] = box(corner=(-airx/2, -airy/2, -airz/2), size=(airx, airy, airz))
  substrate_signal_dummy_SweepFaceAlongNormal1 [sapphire, non-model] = sweep_along_normal(substrate_signal_dummy.face(at (0, 0, 0.25)), length=-2*(mask_align_tol +spillar_r)-dielectric_overlap)
  substrate_signal_dummy_SweepFaceAlongNormal1_SweepFaceAlongNormal1 [sapphire, non-model] = sweep_along_normal(substrate_signal_dummy_SweepFaceAlongNormal1.face(at (0.3, 0, 0.25)), length=comp_len)
  substrate_signal_dummy_SweepFaceAlongNormal1_SweepFaceAlongNormal1_Section1 [sapphire, non-model] = substrate_signal_dummy_SweepFaceAlongNormal1_SweepFaceAlongNormal1.section(plane=ZX)
  substrate_signal_dummy_SweepFaceAlongNormal1_SweepFaceAlongNormal1_Section1.thicken(comp_width, both sides)
  substrate_signal_dummy_Split1 [sapphire, non-model] = substrate_signal_dummy.split(plane=substrate_signal_dummy_SweepFaceAlongNormal1_SweepFaceAlongNormal1_Section1_1.face(4 of 6), keep=Both)
  substrate_signal_dummy_SweepFaceAlongNormal1_SweepFaceAlongNormal1_Section1_1 = substrate_signal_dummy_SweepFaceAlongNormal1_SweepFaceAlongNormal1_Section1.copy()
  substrate_signal_dummy_SweepFaceAlongNormal1_SweepFaceAlongNormal1_Section1_1.delete()
  substrate_signal_overlap [gold] = sweep_along_normal(substrate_signal_dummy_SweepFaceAlongNormal1.face(at (0.15, 0, 0.5)), length=Tmet)
  compensation [gold] = sweep_along_normal(substrate_signal_dummy_SweepFaceAlongNormal1_SweepFaceAlongNormal1_Section1.face(at (0.35, 0, 0.5)), length=Tmet)
  substrate_signal [gold] = sweep_along_normal(substrate_signal_dummy.face(at (0.45, 0, 0.5)), length=Tmet)
  trace_overlap_SweepFaceAlongNormal1 [sapphire] = sweep_along_normal(trace_overlap.face(at (0.11, 0, 0.804)), length=dielectric_overlap)
boundaries and excitations:
  Rad1: Radiation Objects=air_box
  FiniteCond1: Finite Conductivity Objects=[chip_gnd_1, chip_gnd_1_overlap, chip_gnd_2, chip_gnd_2_overlap, chip_signal, chip_signal_overlap, compensation, gnd1_pillar, gnd2_pillar, sig_pillar, substrate_gnd_2, substrate_gnd_1, substrate_signal, substrate_signal_overlap] UseMaterial Material=gold Roughness=100nm IsInternal
  1: Wave Port Objects=Port1 WavePortType=Modal NumModes=1 Modes{Mode1{IntLine{(0.5, 0.01225, 0.502) -> (0.5, 0.02237, 0.502)} CharImp=Zpv RenormImp=50ohm}}
  2: Wave Port Objects=Port2 WavePortType=Modal NumModes=1 Modes{Mode1{IntLine{(-0.5, 0.01225, 0.554) -> (-0.5, 0.02237, 0.554)} CharImp=Zpv RenormImp=50ohm}}
setups:
  bb_1to50: HfssDriven MultipleAdaptiveFreqsSetup{Low=1GHz High=50GHz} MaxDeltaS=0.02 MaximumPasses=15 MinimumPasses=1 MinimumConvergedPasses=1 PercentRefinement=30 BasisOrder=1 PortAccuracy=0.02 UseABCOnPort DrivenSolverType="Direct Solver"
    sweep Sweep: 1GHz to 50GHz, 1001 points; Type=Interpolating InterpTolerance=0.5 InterpMaxSolns=250 PassivityErrorTolerance=0.0001
source amplitudes:
  1:1: 1V 0deg
  2:1: 0V 0deg
optimetrics:
  ParametricSetup1: Parametric Sim._Setups=[bb_1to50]
    sweep comp_len: LIN 190um 210um 2um
  OptimizationSetup1: Optimization disabled Optimizer="kDX ASO" AnalysisStopOptions{StopForNumIteration MaxNumIteration=32 MinNumIteration=10} CostFuncNormType=L2 Acceptable_Cost=0.5 Noise=0.0001 UpdateDesignWhenDone
    vary comp_len: Min=185um Max=205um MinStep=0.27um MaxStep=2.7um MinFocus=13.5um MaxFocus=40.5um start=190um
    goal dB(St(1,1)) <= -20 weight 1 on bb_1to50 : Sweep at Freq 1GHz to 40GHz
output variables:
  lost_power_fraction = 1-(mag(St(1,1))^2 + mag(St(2,1))^2)
  Zl = mag(Zo(1))*(1-mag(S(1,1)))/(1+mag(S(1,1)))
  L = -im(1/Yt(1,2))/(2*3.14*Freq)
  C_chip = (im(Y(1,1) + Y(2,1)) )/ (2 * pi * Freq)
  C_sub = (im(Y(2,2) + Y(2,1)) )/ (2 * pi * Freq)
reports:
  Terminal S Parameter Plot1: dB(St(1,1)) vs Freq on bb_1to50 : Sweep; markers MX1 at x=4.5e+10, MX2 at x=4e+10, MX3 at x=2.7e+10
  Output Variables Plot1: lost_power_fraction vs Freq on bb_1to50 : Sweep
