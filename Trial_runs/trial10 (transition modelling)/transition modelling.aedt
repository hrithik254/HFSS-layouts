# Ansys Electronics Desktop project, version 2025.1
materials:
  air: permittivity=1.0006 permeability=1.0000004
  gallium_arsenide: permittivity=12.9 conductivity=1e-05
  gold: permeability=0.99996 conductivity=41000000
  sapphire: permittivity=9.4
  vacuum: permittivity=1
  copper: permeability=0.999991 conductivity=58000000

design CPW_transition (HFSS, HFSS Terminal Network, model units mm)
variables:
  subx = 2mm
  suby = s + 2*(g+gnd_width) + 3000um
  subz = 500um
  s = 60um
  g = 28.5um
  gnd_width = 200um
  Tmet = 2um
  air_box_h = subz + 15000um
  porty = 3*(2*g+s)
  portz = 2*subz
  airx = subx
  airy = suby+15000um
  abpillarx = 20um
  abpillary = 20um
  abpillarz = 4um
  transition_gap = 1000um
  pillarh = 80um  # optimise 40um..120um
  sig_p_r = 20um
  overlay_pad = overlay_tol
  g_pillar_seperation = 100um
  gnd_p_r = 30um
  chipx = transition_gap+ 2*overlay_tol + 2*dielectric_overlap
  chipy = 3mm
  overlay_tol = 50um  # optimise 25um..75um
  dielectric_overlap = 1mm
  chip_s = 60um
  chip_g = 51um
  chip_gnd_width = 200um
  bonder_tol = 10um
  trace_overlap = transition_gap + 2* overlay_tol + 4*gnd_p_r + bonder_tol
geometry:
  substrate [sapphire] = box(corner=(-subx/2, -suby/2, 0mm), size=(subx, suby, subz))
  signal_dummy [vacuum, non-model] = substrate.section(plane=ZX)
  signal_dummy.thicken(s, both sides)
  gap_dummy1 [vacuum, non-model] = sweep_along_normal(signal_dummy.face(at (0, -0.03, 0.25)), length=g)
  gap_dummy2 [vacuum, non-model] = sweep_along_normal(signal_dummy.face(at (0, 0.03, 0.25)), length=g)
  gnd_dummy1 [vacuum, non-model] = sweep_along_normal(gap_dummy1.face(at (0, -0.0585, 0.25)), length=gnd_width)
  gnd_dummy2 [vacuum, non-model] = sweep_along_normal(gap_dummy2.face(at (0, 0.0585, 0.25)), length=gnd_width)
  port1 = rectangle(corner=(subx/2, -porty/2, 50um), y_size=porty, z_size=portz)
  port2 = rectangle(corner=(-subx/2, -porty/2, 50um), y_size=porty, z_size=portz)
  airbox [air] = box(corner=(-airx/2, -airy/2, -air_box_h/2), size=(airx, airy, air_box_h))
  backside_gnd [gold] = sweep_along_normal(substrate.face(-z), length=2um)
  substrate_Section1 = substrate.section(plane=YZ)
  substrate_Section1.thicken(transition_gap, both sides)
  substrate_Section1_1 = substrate_Section1.copy()
  gap_dummy1.subtract(substrate_Section1_1)
  substrate_Section1_2 = substrate_Section1.copy()
  gap_dummy2.subtract(substrate_Section1_2)
  substrate_Section1_3 = substrate_Section1.copy()
  gnd_dummy1.subtract(substrate_Section1_3)
  substrate_Section1_4 = substrate_Section1.copy()
  gnd_dummy2.subtract(substrate_Section1_4)
  signal_dummy.subtract(substrate_Section1)
  gnd1_1 [gold] = sweep_along_normal(gnd_dummy1.face(at (0.75, -0.1585, 0.5), at (-0.75, -0.1585, 0.5)), length=Tmet)
  signal1 [gold] = sweep_along_normal(signal_dummy.face(at (0.75, 0, 0.5), at (-0.75, 0, 0.5)), length=Tmet)
  gnd2_1 [gold] = sweep_along_normal(gnd_dummy2.face(at (0.75, 0.1585, 0.5), at (-0.75, 0.1585, 0.5)), length=Tmet)
  p_sig_1 [gold] = cylinder(axis=Z, base_centre=(transition_gap/2 + sig_p_r  + overlay_pad, 0mm, subz+Tmet), radius=sig_p_r, height=pillarh)
  p_gnd_1_1 [gold] = cylinder(axis=Z, base_centre=(transition_gap/2 + sig_p_r  + overlay_pad, -g -s/2 - g_pillar_seperation, subz+Tmet), radius=gnd_p_r, height=pillarh)
  p_gnd_2_1 [gold] = p_gnd_1_1.duplicate_mirror(point=(0.53mm, 0mm, 0.502mm), normal=(2.7755576e-14mm, 1mm, 0mm))
  chip [gallium_arsenide] = box(corner=(-chipx/2, -chipy/2, subz+2*Tmet+pillarh), size=(chipx, chipy, subz))
  chip_signal_dummy [gallium_arsenide, non-model] = chip.section(plane=ZX)
  chip_signal_dummy.thicken(chip_s, both sides)
  chip_gap_dummy2, chip_gap_dummy1 [gallium_arsenide, non-model] = sweep_along_normal(chip_signal_dummy.face(at (0, 0.03, 0.834), at (0, -0.03, 0.834)), length=chip_g)
  chip_gnd_dummy2 [gallium_arsenide, non-model] = sweep_along_normal(chip_gap_dummy2.face(at (0, 0.081, 0.834)), length=chip_gnd_width)
  chip_gnd_dummy1 [gallium_arsenide, non-model] = sweep_along_normal(chip_gap_dummy1.face(at (0, -0.081, 0.834)), length=chip_gnd_width)
  chip_Section1_Section1 [gallium_arsenide, non-model] = chip_signal_dummy.section(plane=YZ)
  chip_Section1_SweepFaceAlongNormal1_Section1 [gallium_arsenide, non-model] = chip_gap_dummy2.section(plane=YZ)
  chip_Section1_SweepFaceAlongNormal2_Section1 [gallium_arsenide, non-model] = chip_gap_dummy1.section(plane=YZ)
  chip_Section1_SweepFaceAlongNormal1_SweepFaceAlongNormal1_Section1 [gallium_arsenide, non-model] = chip_gnd_dummy2.section(plane=YZ)
  chip_Section1_SweepFaceAlongNormal2_SweepFaceAlongNormal1_Section1 [gallium_arsenide, non-model] = chip_gnd_dummy1.section(plane=YZ)
  [chip_Section1_Section1, chip_Section1_SweepFaceAlongNormal1_Section1, chip_Section1_SweepFaceAlongNormal2_Section1, chip_Section1_SweepFaceAlongNormal1_SweepFaceAlongNormal1_Section1, chip_Section1_SweepFaceAlongNormal2_SweepFaceAlongNormal1_Section1].thicken(trace_overlap, both sides)
  chip_gnd1 [gold] = sweep_along_normal(chip_Section1_SweepFaceAlongNormal2_SweepFaceAlongNormal1_Section1.face(at (0, -0.181, 0.584)), length=Tmet)
  chip_gnd2 [gold] = sweep_along_normal(chip_Section1_SweepFaceAlongNormal1_SweepFaceAlongNormal1_Section1.face(at (0, 0.181, 0.584)), length=Tmet)
  chip_signal [gold] = sweep_along_normal(chip_Section1_Section1.face(at (0, 0, 0.584)), length=Tmet)
  backside_gnd.move_faces(MoveAlongNormalFlag=false MoveVectorX=0.6mm MoveVectorY=0mm MoveVectorZ=0mm FacesToMove=backside_gnd.face(at (-0.4, 0, -0.001)))
  substrate.move_faces(MoveAlongNormalFlag=false MoveVectorX=0.6mm MoveVectorY=0mm MoveVectorZ=0mm FacesToMove=substrate.face(-x))
  chip_gnd1.move_faces(MoveAlongNormalFlag=false MoveVectorX=0.2666mm MoveVectorY=0mm MoveVectorZ=0mm FacesToMove=chip_gnd1.face(at (-0.615, -0.181, 0.583)))
  chip_signal.move_faces(MoveAlongNormalFlag=false MoveVectorX=0.2666mm MoveVectorY=0mm MoveVectorZ=0mm FacesToMove=chip_signal.face(at (-0.615, 0, 0.583)))
  chip_gnd2.move_faces(MoveAlongNormalFlag=false MoveVectorX=0.2666mm MoveVectorY=0mm MoveVectorZ=0mm FacesToMove=chip_gnd2.face(at (-0.615, 0.181, 0.583)))
  substrate.move_faces(MoveAlongNormalFlag=false MoveVectorX=0.0516mm MoveVectorY=1.4775mm MoveVectorZ=0.024mm FacesToMove=substrate.face(-x))
  substrate.move_faces(MoveAlongNormalFlag=false MoveVectorX=0.4484mm MoveVectorY=0mm MoveVectorZ=0mm FacesToMove=substrate.face(-x))
  chip.move_faces(MoveAlongNormalFlag=false MoveVectorX=1.2016mm MoveVectorY=1.219mm MoveVectorZ=0mm FacesToMove=chip.face(-x))
  backside_gnd.move_faces(MoveAlongNormalFlag=false MoveVectorX=0.5mm MoveVectorY=3.517mm MoveVectorZ=0mm FacesToMove=backside_gnd.face(at (-0.4, 0, -0.001)))
  port2.move(0.6516mm, 0mm, 0mm)
  chip.move_faces(MoveAlongNormalFlag=false MoveVectorX=-0.935mm MoveVectorY=1.219mm MoveVectorZ=-0.5mm FacesToMove=chip.face(+x))
  airbox.move_faces(MoveAlongNormalFlag=false MoveVectorX=0.6516mm MoveVectorY=9.083mm MoveVectorZ=7.8mm FacesToMove=airbox.face(-x))
boundaries and excitations:
  Rad1: Radiation Faces=airbox.face(-y, +z, -z, +y)
  Rad2: Radiation Faces=airbox.face(+x, -x)
  PerfE1: Perfect E Faces=backside_gnd.face(at (0.55, 0, -0.002))
  1: Wave Port Objects=port1 WavePortType=Modal NumModes=1 DeembedDist=0.385mm Modes{Mode1{IntLine{(1, 0.03, 0.502) -> (1, 0.0585, 0.502)} CharImp=Zpv RenormImp=50ohm}}
  2: Wave Port Objects=port2 WavePortType=Modal NumModes=1 DeembedDist=0.8484mm Modes{Mode1{IntLine{(-0.3484, 0.03, 0.584) -> (-0.3484, 0.081, 0.584)} CharImp=Zpv RenormImp=50ohm}}
setups:
  broadband: HfssDriven MultipleAdaptiveFreqsSetup{Low=1kHz High=40GHz} MaxDeltaS=0.02 MaximumPasses=15 MinimumPasses=1 MinimumConvergedPasses=1 PercentRefinement=30 BasisOrder=1 PortAccuracy=0.1 UseABCOnPort DrivenSolverType="Direct Solver" SaveAnyFields=false
    sweep Sweep: 100kHz to 1MHz, 201 points; Type=Interpolating InterpTolerance=0.5 InterpMaxSolns=250 PassivityErrorTolerance=0.0001
source amplitudes:
  1:1: 1V 0deg
  2:1: 0V 0deg
output variables:
  Zo = 50*(1 + re(St(signal_conductor_T1,signal_conductor_T1)))/(1-re(St(signal_conductor_T1,signal_conductor_T1)))
  lost_power_fraction = 1-(mag(St(1,1))^2 + mag(St(2,1))^2)
reports:
  Plot1: mag(1/(2*3.14*Yt(1,1)*Freq)) vs Freq on broadband : Sweep
  Plot2: mag((Yt(1,1)-Yt(2,1))/(2*3.14*Freq)) vs Freq on broadband : Sweep
  Plot3: mag((Yt(2,2)-Yt(2,1))/(2*3.14*Freq)) vs Freq on broadband : Sweep

design Q3DDesign1 (Q3D Extractor, model units mm)
options: SParamCalcMethod=EqTransLine Allow_Material_Override Calculate_Lossy_Dielectrics
variables:
  subz = 500um
  g = 28.5um
  gnd_width = 200um
  suby = s + 2*(g+gnd_width) + 3000um
  subx = 2mm
  s = 60um
  transition_gap = 1000um
  porty = 3*(2*g+s)
  portz = 2*subz
  Tmet = 2um
  pillarh = 80um
  sig_p_r = 20um
  overlay_pad = overlay_tol
  overlay_tol = 50um
  gnd_p_r = 30um
  g_pillar_seperation = 100um
  dielectric_overlap = 1mm
  chipx = transition_gap+ 2*overlay_tol + 2*dielectric_overlap
  chipy = 3mm
  chip_s = 60um
  chip_g = 51um
  chip_gnd_width = 200um
  trace_overlap = transition_gap + 2* overlay_tol + 4*gnd_p_r + bonder_tol
  bonder_tol = 10um
  airx = subx
  air_box_h = subz + 15000um
  airy = suby+15000um
geometry:
  substrate [sapphire] = box(corner=(-subx/2, -suby/2, 0mm), size=(subx, suby, subz))
  signal_dummy = substrate.section(plane=ZX)
  backside_gnd [gold] = sweep_along_normal(substrate.face(-z), length=2um)
  substrate_Section1 = substrate.section(plane=YZ)
  substrate.move_faces(MoveAlongNormalFlag=false MoveVectorX=0.6mm MoveVectorY=0mm MoveVectorZ=0mm FacesToMove=substrate.face(-x))
  substrate.move_faces(MoveAlongNormalFlag=false MoveVectorX=0.0516mm MoveVectorY=1.4775mm MoveVectorZ=0.024mm FacesToMove=substrate.face(-x))
  substrate.move_faces(MoveAlongNormalFlag=false MoveVectorX=0.4484mm MoveVectorY=0mm MoveVectorZ=0mm FacesToMove=substrate.face(-x))
  backside_gnd.move_faces(MoveAlongNormalFlag=false MoveVectorX=0.6mm MoveVectorY=0mm MoveVectorZ=0mm FacesToMove=backside_gnd.face(at (-0.4, 0, -0.001)))
  backside_gnd.move_faces(MoveAlongNormalFlag=false MoveVectorX=0.5mm MoveVectorY=3.517mm MoveVectorZ=0mm FacesToMove=backside_gnd.face(at (-0.4, 0, -0.001)))
  signal_dummy.thicken(s, both sides)
  gap_dummy1 = sweep_along_normal(signal_dummy.face(at (0, -0.03, 0.25)), length=g)
  gnd_dummy1 = sweep_along_normal(gap_dummy1.face(at (0, -0.0585, 0.25)), length=gnd_width)
  substrate_Section1.thicken(transition_gap, both sides)
  substrate_Section1_3 = substrate_Section1.copy()
  gnd_dummy1.subtract(substrate_Section1_3)
  gnd1_1 [gold] = sweep_along_normal(gnd_dummy1.face(at (0.75, -0.1585, 0.5), #458), length=Tmet)
  [gap_dummy1, gnd_dummy1].delete()
  gap_dummy2 = sweep_along_normal(signal_dummy.face(#303), length=g)
  substrate_Section1_4 = substrate_Section1.copy()
  signal_dummy.subtract(substrate_Section1)
  signal1 [gold] = sweep_along_normal(signal_dummy.face(at (0.75, 0, 0.5), #335), length=Tmet)
  signal_dummy.delete()
  gnd_dummy2 = sweep_along_normal(gap_dummy2.face(at (0, 0.0585, 0.25)), length=gnd_width)
  gnd_dummy2.subtract(substrate_Section1_4)
  gnd2_1 [gold] = sweep_along_normal(gnd_dummy2.face(at (0.75, 0.1585, 0.5), #521), length=Tmet)
  [gap_dummy2, gnd_dummy2].delete()
  p_sig_1 [gold] = cylinder(axis=Z, base_centre=(transition_gap/2 + sig_p_r  + overlay_pad, 0mm, subz+Tmet), radius=sig_p_r, height=pillarh)
  p_gnd_1_1 [gold] = cylinder(axis=Z, base_centre=(transition_gap/2 + sig_p_r  + overlay_pad, -g -s/2 - g_pillar_seperation, subz+Tmet), radius=gnd_p_r, height=pillarh)
  p_gnd_2_1 [gold] = p_gnd_1_1.duplicate_mirror(point=(0.53mm, 0mm, 0.502mm), normal=(2.7755576e-14mm, 1mm, 0mm))
  chip = box(corner=(-chipx/2, -chipy/2, subz+2*Tmet+pillarh), size=(chipx, chipy, subz))
  chip_signal_dummy = chip.section(plane=ZX)
  chip_signal_dummy.thicken(chip_s, both sides)
  chip_gap_dummy2, chip_gap_dummy1 = sweep_along_normal(chip_signal_dummy.face(at (0, 0.03, 0.834), at (0, -0.03, 0.834)), length=chip_g)
  chip_gnd_dummy1 = sweep_along_normal(chip_gap_dummy1.face(at (0, -0.081, 0.834)), length=chip_gnd_width)
  chip_Section1_SweepFaceAlongNormal2_SweepFaceAlongNormal1_Section1 = chip_gnd_dummy1.section(plane=YZ)
  chip_Section1_SweepFaceAlongNormal2_SweepFaceAlongNormal1_Section1.thicken(trace_overlap, both sides)
  chip_gnd1 [gold] = sweep_along_normal(chip_Section1_SweepFaceAlongNormal2_SweepFaceAlongNormal1_Section1.face(at (0, -0.181, 0.584)), length=Tmet)
  [chip, chip_gap_dummy1, chip_gnd_dummy1, chip_Section1_SweepFaceAlongNormal2_SweepFaceAlongNormal1_Section1].delete()
  chip_gnd1.move_faces(MoveAlongNormalFlag=false MoveVectorX=0.2666mm MoveVectorY=0mm MoveVectorZ=0mm FacesToMove=chip_gnd1.face(at (-0.615, -0.181, 0.583)))
  chip_gnd_dummy2 = sweep_along_normal(chip_gap_dummy2.face(at (0, 0.081, 0.834)), length=chip_gnd_width)
  chip_Section1_SweepFaceAlongNormal1_SweepFaceAlongNormal1_Section1 = chip_gnd_dummy2.section(plane=YZ)
  chip_Section1_SweepFaceAlongNormal1_SweepFaceAlongNormal1_Section1.thicken(trace_overlap, both sides)
  chip_gnd2 [gold] = sweep_along_normal(chip_Section1_SweepFaceAlongNormal1_SweepFaceAlongNormal1_Section1.face(at (0, 0.181, 0.584)), length=Tmet)
  [chip_gap_dummy2, chip_gnd_dummy2, chip_Section1_SweepFaceAlongNormal1_SweepFaceAlongNormal1_Section1].delete()
  chip_gnd2.move_faces(MoveAlongNormalFlag=false MoveVectorX=0.2666mm MoveVectorY=0mm MoveVectorZ=0mm FacesToMove=chip_gnd2.face(at (-0.615, 0.181, 0.583)))
  chip_Section1_Section1 = chip_signal_dummy.section(plane=YZ)
  chip_Section1_Section1.thicken(trace_overlap, both sides)
  chip_signal [gold] = sweep_along_normal(chip_Section1_Section1.face(at (0, 0, 0.584)), length=Tmet)
  [chip_signal_dummy, chip_Section1_Section1].delete()
  chip_signal.move_faces(MoveAlongNormalFlag=false MoveVectorX=0.2666mm MoveVectorY=0mm MoveVectorZ=0mm FacesToMove=chip_signal.face(at (-0.3484, 0, 0.583)))
  airbox [air] = box(corner=(-airx/2, -airy/2, -air_box_h/2), size=(airx, airy, air_box_h))
  airbox.move_faces(MoveAlongNormalFlag=false MoveVectorX=0.6516mm MoveVectorY=9.083mm MoveVectorZ=7.8mm FacesToMove=airbox.face(-x))
  chip1 [gallium_arsenide] = box(corner=(-chipx/2, -chipy/2, subz+2*Tmet+pillarh), size=(chipx, chipy, subz))
  chip1.move_faces(MoveAlongNormalFlag=false MoveVectorX=1.2016mm MoveVectorY=1.219mm MoveVectorZ=0mm FacesToMove=chip1.face(-x))
  chip1.move_faces(MoveAlongNormalFlag=false MoveVectorX=-0.935mm MoveVectorY=1.219mm MoveVectorZ=-0.5mm FacesToMove=chip1.face(+x))
boundaries and excitations:
  SignalNet1: SignalNet Objects=[signal1, p_sig_1, chip_signal]
  GroundNet1: GroundNet Objects=[gnd2_1, p_gnd_2_1, chip_gnd2]
  GroundNet2: GroundNet Objects=[gnd1_1, p_gnd_1_1, chip_gnd1]
  FloatingNet1: FloatingNet Objects=backside_gnd
  Source1: Source Faces=signal1.face(at (1, 0, 0.501)) TerminalType=ConstantVoltage Net=SignalNet1
  Sink1: Sink Faces=chip_signal.face(at (-0.3484, 0, 0.583)) TerminalType=ConstantVoltage Net=SignalNet1
setups:
  Setup1: Matrix AdaptiveFreq=33.5GHz Cap{MaxPass=10 MinPass=1 MinConvPass=1 PerError=1 PerRefine=30 AutoIncreaseAccuracy AccuracyLevel=High Solver_Type=Iterative} DC{Cond{MaxPass=10 MinPass=1 MinConvPass=1 PerError=1 PerRefine=30} Mult{MaxPass=1 MinPass=1 MinConvPass=1 PerError=1 PerRefine=30} AccuracyLevel=Normal} AC{MaxPass=10 MinPass=1 MinConvPass=1 PerError=1 PerRefine=30 ACRLSolverType=ACA} ErrorValue=0.1
    sweep Sweep1: 27GHz to 40GHz, 20 points; Type=Interpolating InterpTolerance=0.5 InterpMaxSolns=50
source amplitudes:
  SignalNet1:Source1: AC R/L Fields 1A 0deg
  SignalNet1: CG Fields 1V 0deg
  SignalNet1:Source1: DC R/L Fields 1A 0deg
reports:
  C Matrix Plot1: C(SignalNet1,SignalNet1) vs Freq on Setup1 : Sweep1
  G Matrix Plot1: G(SignalNet1,SignalNet1) vs Freq on Setup1 : Sweep1
  DCL Matrix Plot1: DCL(SignalNet1:Source1,SignalNet1:Source1) vs Freq on Setup1 : Sweep1
